.lib /home/mrquan/.volare/sky130A/libs.tech/combined/sky130.lib.spice tt
