** sch_path: /home/mrquan/VLSI/vlsi-/proj/xschem/inv.sch
.subckt inv in out vdd gnd
*.PININFO in:I out:O vdd:B gnd:B
XMP out in vdd vdd sky130_fd_pr__pfet_01v8 L=0.15 W=3 nf=1 m=1
XMN out in gnd gnd sky130_fd_pr__nfet_01v8 L=0.15 W=1 nf=1 m=1
.ends
.end
