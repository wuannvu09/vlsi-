** sch_path: /home/mrquan/VLSI/vlsi-/proj/xschem/and2.sch
.subckt and2 a b y vdd gnd
*.PININFO a:I b:I y:O vdd:B gnd:B
X1 a b net1 vdd gnd nand2
X2 net1 y vdd gnd inv
.ends

* expanding   symbol:  nand2.sym # of pins=5
** sym_path: /home/mrquan/VLSI/vlsi-/proj/xschem/nand2.sym
** sch_path: /home/mrquan/VLSI/vlsi-/proj/xschem/nand2.sch
.subckt nand2 a b y vdd gnd
*.PININFO a:I b:I y:O vdd:B gnd:B
XMPA y a vdd vdd sky130_fd_pr__pfet_01v8 L=0.15 W=3 nf=1 m=1
XMPB y b vdd vdd sky130_fd_pr__pfet_01v8 L=0.15 W=3 nf=1 m=1
XMNA y a net1 gnd sky130_fd_pr__nfet_01v8 L=0.15 W=2 nf=1 m=1
XMNB net1 b gnd gnd sky130_fd_pr__nfet_01v8 L=0.15 W=2 nf=1 m=1
.ends

* expanding   symbol:  inv.sym # of pins=4
** sym_path: /home/mrquan/VLSI/vlsi-/proj/xschem/inv.sym
** sch_path: /home/mrquan/VLSI/vlsi-/proj/xschem/inv.sch
.subckt inv in out vdd gnd
*.PININFO in:I out:O vdd:B gnd:B
XMP out in vdd vdd sky130_fd_pr__pfet_01v8 L=0.15 W=3 nf=1 m=1
XMN out in gnd gnd sky130_fd_pr__nfet_01v8 L=0.15 W=1 nf=1 m=1
.ends

.end
